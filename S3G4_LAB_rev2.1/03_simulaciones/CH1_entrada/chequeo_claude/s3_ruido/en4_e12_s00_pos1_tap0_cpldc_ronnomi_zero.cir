* S3 e12_s00_pos1_tap0_cpldc_ronnomi_zero
.include "C:\Users\Keneth\Desktop\S3G4 LAB\S3G4_LAB_rev2.1\03_simulaciones\CH1_entrada\comun\ch1_comun_s3.inc"
.include "C:\Users\Keneth\Desktop\S3G4 LAB\Simulation_LTSpice\models\OPA810\opa810_a.lib"
.include "C:\Users\Keneth\Desktop\S3G4 LAB\S3G4_LAB_rev2.1\03_simulaciones\CH1_entrada\chequeo_claude\s3_ruido\AD8038_en4.sub"
.include "C:\Users\Keneth\Desktop\S3G4 LAB\Simulation_LTSpice\models\74HC4051\hc_tnomi.cir"
.options numdgt=15 plotwinsize=0 threads=1
.options method=gear solver=alt reltol=0.0001 gminsteps=0
.temp 25
.param BUFFER_KIND=810
VP VP 0 5
VN VN 0 -5
CPB VP 0 10u
CND VN 0 10u
CPP VP 0 100n
CNN VN 0 100n
XFE BNC RAWIN VP VN M TAP RSM X1 EQ SEL B T2 FRONT_S2B POS=1 CPL=0
VI101 RAWIN BI 0
VIM101 BO U101M 0
VIP101 VP VP101 0
VIN101 VN VN101 0
X101 BI U101M VP101 VN101 BO BUFFER_OPA810
XLAD BO Y1 Y2 Y3 Y4 Y5 LADDER_S3
RVCHECK Y7 0 1k
XMUX BO Y1 Y2 Y3 Y4 Y5 0 Y7 COMMON A0 A1 A2 VP VN MUX_S3 DYNAMIC=0
CPCB COMMON 0 3p
VIA COMMON IPA 0
VIMA MA IMA 0
VIB OA IPB 0
VIMB MB IMB 0
VIPA VP VPA 0
VINA VN VNA 0
VIPB VP VPB 0
VINB VN VNB 0
X103A IPA IMA VPA VNA OA AD8039_S3
X103B IPB IMB VPB VNB OUT AD8039_S3
RFA OA MA {RF1}
RGA MA 0 {RG1}
CMA MA 0 1p
RFB OUT MB {RF2}
RGB MB 0 {RG2}
CMB MB 0 1p
RLOAD OUT 0 1k
CLOAD OUT 0 10p
VA0 A0 0 0
VA1 A1 0 0
VA2 A2 0 0
Vsrc SRC 0 AC 1
Rsource SRC BNC 50
.meas NOISE e12_s00_pos1_tap0_cpldc_ronnomi_zero_inoise_density_100k FIND V(inoise) AT=100k
.meas NOISE vrms_3m15 INTEG V(inoise) FROM 1 TO 3.15Meg
.meas NOISE vrms_10m INTEG V(inoise) FROM 1 TO 10Meg
.noise V(OUT) Vsrc dec 200 1 10Meg
.end
