* S3 b3_c_s00_pos1_tap0_cpldc_nomi_bipolar_t25
.model BAV99HY D(Is=10.825E-15 N=0.9242 Rs=896.25E-3 Ikf=1.7426E-6 Cjo=640.32E-15 M=0.0662 Vj=0.6504 Isr=9.7471E-9 Bv=100 Tt=4.5428E-9 Iave=0.215 Vpk=100 mfg=Rohm type=Silicon)
.subckt PROTECT_BAV99 COMMON IP IM params: R_SER=470
RSER COMMON IP {R_SER}
DP IP IM BAV99HY
DN IM IP BAV99HY
.ends PROTECT_BAV99
.include "C:\Users\Keneth\Desktop\S3G4 LAB\S3G4_LAB_rev2.1\03_simulaciones\CH1_entrada\comun\ch1_comun_s3b.inc"
.include "C:\Users\Keneth\Desktop\S3G4 LAB\Simulation_LTSpice\models\OPA810\opa810_a.lib"
.include "C:\Users\Keneth\Desktop\S3G4 LAB\Simulation_LTSpice\models\AD8039\AD8038_ltspice.sub"
.include "C:\Users\Keneth\Desktop\S3G4 LAB\Simulation_LTSpice\models\74HC4051\hc_tnomi.cir"
.options numdgt=15 plotwinsize=0 threads=1
.options method=gear solver=alt reltol=0.0001 gminsteps=0
.temp 25
.param BUFFER_KIND=810
VP VP 0 5
VN VN 0 -5
CPB VP 0 10u
CND VN 0 10u
CPP VP 0 100n
CNN VN 0 100n
XFE BNC RAWIN VP VN M TAP RSM X1 EQ SEL B T2 FRONT_S2B POS=1 CPL=0
VI101 RAWIN BI 0
VIM101 BO U101M 0
VIP101 VP VP101 0
VIN101 VN VN101 0
X101 BI U101M VP101 VN101 BO_DRIVE BUFFER_OPA810
XLAD BO Y1 Y2 Y3 Y4 Y5 LADDER_S3
RVCHECK Y7 0 1k
XMUX BO Y1 Y2 Y3 Y4 Y5 0 Y7 COMMON A0 A1 A2 VP VN MUX_S3 DYNAMIC=0
CPCB COMMON 0 3p
VIA COMMON SER_IN 0
VIMA MA IMA 0
VIB OA SERB 0
XPROTB SERB IPB IMB PROTECT_BAV99 R_SER=470
VIMB MB IMB 0
VIPA VP VPA 0
VINA VN VNA 0
VIPB VP VPB 0
VINB VN VNB 0
X103A IPA IMA VPA VNA OA AD8039_S3
X103B IPB IMB VPB VNB OUT AD8039_S3
RFA OA MA {RF1}
RGA MA 0 {RG1}
CMA MA 0 1p
RFB OUT MB {RF2}
RGB MB 0 {RG2}
CMB MB 0 1p
RLOAD OUT 0 1k
CLOAD OUT 0 10p
VA0 A0 0 0
VA1 A1 0 0
VA2 A2 0 0
VOUT101 BO_DRIVE BO 0
XPROT SER_IN IPA IMA PROTECT_BAV99 R_SER=470
Vsrc SRC 0 0
Vsource_link SRC BNC 0
.save V(SRC) V(BNC) V(BI) V(BO) V(COMMON) V(IPA) V(IMA) V(IPB) V(IMB) V(OA) V(OUT) I(VI101) I(VIM101) I(VIA) I(VIMA) I(VIB) I(VIMB) I(VOUT101) I(VIP101) I(VIN101) I(VIPA) I(VINA) I(VIPB) I(VINB) I(XPROT:DP) I(XPROT:DN)
.dc Vsrc -40 40 .05
.meas DC dA MAX abs(V(IPA,IMA))
.meas DC dB MAX abs(V(IPB,IMB))
.meas DC isw MAX abs(I(VIA))
.meas DC iopa MAX abs(I(VOUT101))
.end
