* Chequeo Claude S4: ruido del OPA836 como seguidor frente a 4.6 nV/rtHz de hoja
.include "C:\Users\Keneth\Desktop\S3G4 LAB\Simulation_LTSpice\models\OPA836\opa836_a.lib"
VDD vdd 0 3.3
VI in 0 1.25 AC 1
X1 in o o vdd 0 vdd OPA836
RL o 0 2k
.noise V(o) VI dec 20 10 10Meg
.meas noise en100k FIND V(inoise) AT=100k
.meas noise en1m FIND V(inoise) AT=1Meg
.meas noise iq param 0
.end
