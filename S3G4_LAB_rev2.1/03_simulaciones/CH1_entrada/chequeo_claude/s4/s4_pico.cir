* Chequeo Claude S4: OPA836 a 3.3 V; seguidor y S4 (sumadora inversora) con carga 68 ohm + 470 pF
.include "C:\Users\Keneth\Desktop\S3G4 LAB\Simulation_LTSpice\models\OPA836\opa836_a.lib"
VDD vdd 0 3.3
VREF vref 0 2.5
RT vref vmid 10.0k
RB vmid 0 5.23k
CMID vmid 0 1u
* seguidor polarizado en 1.25 V
VI1 in1 0 1.25 AC 1
X1 in1 o1 o1 vdd 0 vdd OPA836
RL1 o1 0 2k
* S4
VIN in 0 0 AC 1
VDAC dac 0 1.25
RIN in sum 10.0k
RF o2 sum 10.0k
ROFF dac sum 8.06k
CS sum 0 {CSUM}
CF o2 sum {CFB}
X2 vmid sum o2 vdd 0 vdd OPA836
RADC o2 pin 68
CADC pin 0 {CAD}
.param CSUM=1p CFB=0 CAD=470p
.step param CSUM list 0 1p
.step param CFB list 0 1p 2.2p 4.7p
.step param CAD list 0 470p
.ac dec 100 1k 1G
.meas ac g1 FIND mag(V(o1)) AT=1k
.meas ac f1 WHEN mag(V(o1))=g1/sqrt(2) FALL=1
.meas ac g2 FIND mag(V(o2)) AT=1k
.meas ac p2 MAX mag(V(o2))
.meas ac fp2 WHEN mag(V(o2))=p2
.meas ac f2 WHEN mag(V(o2))=g2/sqrt(2) FALL=1
.meas ac l2 FIND mag(V(o2)) AT=2Meg
.meas ac op1 FIND V(o2) AT=1k
.end
