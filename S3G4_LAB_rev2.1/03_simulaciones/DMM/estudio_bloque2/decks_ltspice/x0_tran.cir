* Bloque 2 - X0: capacidad no lineal del 4051 (COM y Y) y BAV199 reales; seno de 2 Vpk (rango de 2 V) a f
.include "C:\Users\Keneth\Desktop\S3G4 LAB\Simulation_LTSpice\models\OPA2188\OPAx188.LIB"
.include bav199_mod.lib
.param f=20k amp=2 b=0.1 Ccom=18.5p Cy=5p
Vcc vcc 0 4.9
Vee vee 0 -4.9
Vin in 0 SINE(0 {amp} {f})
Rp in x0p 99k
* BAV199 (modelo Nexperia): D1 del nodo al +4.9, D2 del -4.9 al nodo
D1 x0p vcc BAV199
D2 vee x0p BAV199
Cpcb x0p 0 3p
* pata Yn con capacidad no lineal C=Cy*(1+b*v)
Cy x0p 0 Q={Cy}*V(x0p)*(1+{b}/2*V(x0p))
Rs x0p x0m 100
Ron x0m com 100
* COM 4051: 25 pF no lineal + 3 pF de pista
Cz com 0 Q=25p*V(com)*(1+{b}/2*V(com))
Cpc com 0 3p
XU1 com out vcc vee out OPAx188
.tran 0 {20/f+60/f} {20/f} {1/f/200}
.four {f} 5 v(out)
.meas tran vpk MAX v(out) from {20/f} to {80/f}
.meas tran vmn MIN v(out) from {20/f} to {80/f}
.meas tran vrms RMS v(out) from {20/f} to {80/f}
.end
