* Estudio bloque 3 - fuente de corriente P43 (MOS)
.include "C:\Users\Keneth\Desktop\S3G4 LAB\Simulation_LTSpice\models\TLV2372\TLV2372.LIB"
.model NPNREF NPN(IS=1e-14 BF=200 VAF=100 CJE=8p CJC=4p TF=0.4n)
.model PNPPAS PNP(IS=1e-14 BF=150 VAF=100 CJE=8p CJC=4p TF=0.4n XTB=1.5 ISE=1e-16 NE=1.5 IKF=0.05)
.model BSS84 VDMOS(pchan Rg=3 Vto=-2.0 Rd=2.4 Rs=1.8 Rb=3 Kp=.2 Cgdmax=.04n Cgdmin=.001n Cgs=.02n Cjo=.01n Is=2p ksubthres=.1)
.model BAT54 D(Is=.1u Rs=2.2 N=1 Cjo=12p M=.3 Eg=.69 Xti=2)
Vp vp 0 4.8
Vn vn 0 -4.8
Vref ref 0 2.5
* etapa 1: V_set = VREF*R2/R1 bajo el riel
XU1 ref e1 vp vn o1 TLV2372
Rb1 o1 b1 10k
Q1 cn b1 e1 NPNREF
R1 e1 0 24.9k
R2 vp cn 4.99k
* etapa 2: amplificador B + elemento de paso. R_k entre riel y S; 4051 de fuerza (Ron 110, Cz 25p) entre S y F; sentido por 4051 (Ron 110, Cz 25p + Cin 8p)
Rk vp s 499
Rf s f 110
Cz f 0 25p
Cy s 0 5p
Rsn s sno 1000.0
Vsn sno sni 0
Cs sni 0 33p
Ct sni 0 0
XU2 cn sni vp vn ogi TLV2372
Vinj ogi og 0 AC 1
Cc og sni 1n
Rg og gate 1k
M1 d gate f f BSS84
* opcion c: el BAT54 inyecta en N1 (nodo de la TVS); R_S y las sujeciones quedan como rama de falta (no se modelan)
Dblk d n1 BAT54
Ctvs n1 0 600p
R1c n1 bor 1530
Cbor bor 0 25p
Rx bor 0 1000000000000.0
Rdiv bor 0 10.01Meg
.include "C:\Users\Keneth\Desktop\S3G4 LAB\Simulation_LTSpice\models\OPA2192\OPAx192.LIB"
.model BAV199 D(IS=805.84E-18 N=1.0246 RS=.05 IKF=362.16E-6 CJO=1.9002E-12 M=.35193 VJ=1.2722 ISR=298.95E-15 BV=113.30 IBV=10 TT=1.0230E-6)
* camino X0: R_PROT 99k, sujecion BAV199, 10k, buffer, mux (Ron 70, Cz 25p), A x10.1 (91k/10k)
Rp bor x0p 99k
Cp0 x0p 0 3p
D0p x0p vp BAV199
D0n vn x0p BAV199
Rx0 x0p bi0 10k
Cin bi0 0 9p
Xbuf bi0 bx0 vp vn bx0 OPAx192
Rmux bx0 mux 70
Czm mux 0 28p
Rfg out inv 91k
Rgg inv 0 10k
Ctm inv 0 5p
Xamp mux inv vp vn out OPAx192
Rload out vcm 10k
Cload out vcm 10p
Vcm vcm 0 1.25
* PB14: divisor /2 y 5 pF
Rd1 out pb14 10k
Rd2 pb14 0 10k
Cpb pb14 0 5p
Ssh bor 0 ctl 0 SWC
Vctl ctl 0 PULSE(0 1 0.003 10n 10n 1 2)
.model SWC SW(Ron=40 Roff=1G Vt=0.5 Vh=0)
.options method=gear reltol=0.003
.tran 0 0.0034 0 0.2u startup
.end
